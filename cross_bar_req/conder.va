// VerilogA for MyLib, conder, veriloga

`include "constants.vams"
`include "disciplines.vams"

module conder(a, b);
	inout a, b ;
	electrical a, b ; // access functions are V() and I()

	parameter real Ec = 1.9;
	parameter real dT = 1e-9;
	parameter real l = 500e-9;
	parameter real w = 500e-9;
	parameter real p00 = 25e-2;
//	parameter real p0 = 1e-12;
//	parameter real p0 = 1e-14;

	localparam real S = l * w;
	localparam real p0 = p00*(2*S);
	localparam real alpha = 3*sqrt(3)*Ec/(8*p0*p0*p0);
	localparam real beta = -3*sqrt(3)*Ec/(4*p0);

	real p;
	real de;
	real Rdamp;

	analog begin
//		@(initial_step("tran")) $display("%e %e", p0, p);;
		de = V(a, b) - 2*beta*p - 4*alpha*p**3;
		Rdamp = (+beta+(24*alpha*p0*p0))*dT;
		p = idt(de/Rdamp, p0);
		I(a, b) <+ ddt(p);
//		$display("%e", $abstime) ;
//		$display(p);
//		$display("%e %e", p0, p);

	end

endmodule
